.subckt sky130_fd_sc_hd__inv_1 A VGND VNB VPB VPWR Y
XM0 Y A VGND VNB sky130_fd_pr__nfet_01v8 L=0.15 W=1.3 nf=1 m=1
XM1 Y A VPWR VPB sky130_fd_pr__pfet_01v8_hvt L=0.15 W=1 nf=1 m=1
.ends
